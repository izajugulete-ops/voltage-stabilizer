** Profile: "SCHEMATIC1-Sim_Iz"  [ C:\Users\Izabela\OneDrive\Desktop\P1_2025_432D_Jugulete_Izabela_Ana-Maria_SERS_Tema7_17_OrCADg\Schematics\stabilizator-pspicefiles\schematic1\sim_iz.sim ]

** Creating circuit file "Sim_Iz.cir"
** WARNING: THIS AUTOMATICALLY GENERATED FILE MAY BE OVERWRITTEN BY SUBSEQUENT SIMULATIONS

*Libraries:
* Profile Libraries :
* Local Libraries :
.LIB "../../../lib_modelepspice_anexa_1/lib_modelepspice_anexa_1/modele_a1_lib/bc856b.lib"
.LIB "../../../lib_modelepspice_anexa_1/lib_modelepspice_anexa_1/modele_a1_lib/bc846b.lib"
.LIB "../../../lib_modelepspice_anexa_1/lib_modelepspice_anexa_1/modele_a1_lib/1n4148.lib"
.LIB "../../../lib_modelepspice_anexa_1/lib_modelepspice_anexa_1/modele_a1_lib/bzx84c6v2.lib"
* From [PSPICE NETLIST] section of C:\Users\Izabela\AppData\Roaming\SPB_16.6\cdssetup\OrCAD_PSpice\17.2.0\PSpice.ini file:
.lib "nomd.lib"

*Analysis directives:
.DC LIN V1 0 36 0.1
.OPTIONS ADVCONV
.PROBE64 V(alias(*)) I(alias(*)) W(alias(*)) D(alias(*)) NOISE(alias(*))
.INC "..\SCHEMATIC1.net"

.END
