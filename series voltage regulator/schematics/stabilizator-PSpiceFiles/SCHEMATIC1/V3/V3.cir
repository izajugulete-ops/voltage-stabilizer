** Profile: "SCHEMATIC1-V2"  [ C:\OrCAD\OrCAD_16.6_Lite\tools\capture\stabERSiz-PSpiceFiles\SCHEMATIC1\V2.sim ]

** Creating circuit file "V2.cir"
** WARNING: THIS AUTOMATICALLY GENERATED FILE MAY BE OVERWRITTEN BY SUBSEQUENT SIMULATIONS

*Libraries:
* Profile Libraries :
* Local Libraries :
.LIB "c:/users/izaju/downloads/modele pspice_anexa 1 (1)/lib_modelepspice_anexa_1/lib_modelepspice_anexa_1/modele_a1_lib/1n4148.lib"
+ ""
.LIB "c:/users/izaju/downloads/modele pspice_anexa 1 (1)/lib_modelepspice_anexa_1/lib_modelepspice_anexa_1/modele_a1_lib/bc846b.lib"
+ ""
.LIB "c:/users/izaju/downloads/modele pspice_anexa 1 (1)/lib_modelepspice_anexa_1/lib_modelepspice_anexa_1/modele_a1_lib/bc856b.lib"
+ ""
.LIB "c:/users/izaju/downloads/modele pspice_anexa 1 (1)/lib_modelepspice_anexa_1/lib_modelepspice_anexa_1/modele_a1_lib/bzx84c6v2."
+ "lib"
* From [PSPICE NETLIST] section of C:\Users\izaju\AppData\Roaming\SPB_Data\cdssetup\OrCAD_PSpice/16.6.0/PSpice.ini file:
.lib "nomd.lib"

*Analysis directives:
.DC LIN V_V1 0 34 0.1
.OPTIONS ADVCONV
.PROBE64 V(alias(*)) I(alias(*)) W(alias(*)) D(alias(*)) NOISE(alias(*))
.INC "..\SCHEMATIC1.net"

.END
